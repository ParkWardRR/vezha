* SIM-12  TLC59116 power dissipation and junction temperature
*
* RETIRED 2026-11-18 -- PCB 1 is not built in v1. There are no RGB
*   indicators and no LED driver. See docs/01 "The v1 scope cut".
*   Kept for v2: the finding that red is the hot channel on a 5 V anode
*   is a property of the part, not of this board.
*
* QUESTION
*   docs/04-pcb-1-front-control.md puts four RGB indicators on a TLC59116 in
*   TSSOP-28, with "LED anodes off the upper box's 5 V rail, driver logic on
*   3.3 V". Nobody has checked what that costs the driver in heat. A
*   constant-current sink burns (V_anode - Vf) * I in the chip, and a 5 V
*   anode against a ~2 V red LED burns most of it.
*
* WHY THE 5 V RAIL IS NOT FREE
*   The driver sinks current; whatever the LED does not drop, the chip does.
*     red   Vf ~1.9-2.2 V  ->  chip drops ~3.0 V
*     green Vf ~2.9-3.4 V  ->  chip drops ~1.9 V
*     blue  Vf ~2.9-3.4 V  ->  chip drops ~1.9 V
*   Red is therefore the hottest channel despite being the dimmest colour,
*   which is not obvious from the schematic.
*   LED CHOSEN 2026-11-18: MEIHUA MHPA2525RGBDT-S, LCSC C404285.
*   Its datasheet Vf spread is WORSE for the driver than the generic figures
*   this deck first used:
*     red   Vf 1.6-2.6 V  -> worst case chip drops 3.4 V (was 3.0)
*     G/B   Vf 2.4-3.6 V  -> worst case chip drops 2.6 V (was 1.9)
*   Worst case means LOWEST Vf, because the chip eats the remainder.
*   Defaults below are set to that worst case, not the typical.
*
* CURRENT IS A DESIGN CHOICE, NOT A GIVEN
*   TLC59116 output current is set by one resistor on REXT:
*     IOUT = (1.25 V / Rext) x 15      (power-on defaults VG=127/128, CM=1)
*   TI's own example: 931 ohm -> 20 mA. So 1.87 k -> 10.03 mA.
*   This deck exists to pick that resistor.
*
* WHY NOT JUST USE 3.3 V FOR THE ANODES
*   Blue and green need 2.9-3.4 V plus the driver's own output headroom. A
*   3.3 V anode cannot guarantee full current into a 3.4 V blue die. So 5 V
*   is right for blue/green and wasteful for red. That asymmetry is the whole
*   finding here.
*
* MODEL
*   One channel = anode rail -> LED (modelled as a fixed Vf) -> optional
*   ballast R -> ideal current sink inside the chip. LED dynamic resistance
*   is ignored; for dissipation arithmetic at a fixed sink current that is
*   exact, because the sink sets the current regardless.
*
* IREF CAVEAT
*   The external IREF resistor that sets per-channel current is NOT computed
*   here - the TLC59116 datasheet formula has not been pulled. Current is
*   swept as an independent parameter instead.
*
* PASS CRITERIA
*   TLC59116 absolute max Tj = 125 C. Target Tj <= 100 C for margin.
*   Enclosure A is a sealed 3D print with an RK3588 in it and no measured
*   thermal solution (docs/02), so 50-60 C internal ambient is the honest
*   worst case, not 25 C.
*
* RESULT (re-run 2026-11-18 with the chosen LED)
*   The LED choice made this WORSE, which is why it was worth re-running.
*   At 20 mA all 12 channels draw 0.688 W (was 0.544 W on generic Vf),
*   giving Tj 115 C at 60 C ambient - over target and near the 125 C max.
*
*   THE FIX IS THE REXT RESISTOR, not firmware and not ballast:
*     Rext 931  -> 20.1 mA -> 0.693 W -> Tj 115 C   FAIL
*     Rext 1500 -> 12.5 mA -> 0.430 W -> Tj  94 C   ok
*     Rext 1870 -> 10.0 mA -> 0.345 W -> Tj  88 C   CHOSEN
*     Rext 3000 ->  6.3 mA -> 0.215 W -> Tj  77 C   ok, dimmer than needed
*
*   DECISION: Rext = 1.87 k, 1%. 10 mA per channel, Tj 88 C worst case.
*   The LED is 250-1600 mcd at 20 mA; half of that through a diffuser is
*   still far more than a status indicator needs, so nothing is lost.
*   Firmware can still scale DOWN via the IREF gain bits; this only sets
*   the ceiling, and sets it somewhere the chip is safe at full white.
*
*   Ballast on the red channels (SIM-12c) is no longer needed at 10 mA.
*   Keep it on record: TI's own datasheet recommends exactly that trick
*   when VLED is high or Vf differs between channels, which is this case.

.title SIM-12 TLC59116 dissipation

.param ILED  = 20m
.param VFRED = 1.6
.param VFGB  = 2.4
.param VANODE = 5.0
.param RBAL  = 0.001

Vanode anode 0 DC {VANODE}

* --- one red channel ---
Vfr    anode  rmid  DC {VFRED}
Rbr    rmid   rpin  {RBAL}
Ir     rpin   0     DC {ILED}

* --- one green/blue channel ---
Vfg    anode  gmid  DC {VFGB}
Rbg    gmid   gpin  0.001
Ig     gpin   0     DC {ILED}

.control
echo "@@=============================================================="
echo "@@ SIM-12  TLC59116 dissipation, 4 RGB indicators (12 channels)"
echo "@@ 4 red + 8 green/blue. Tj target <= 100 C, abs max 125 C."
echo "@@=============================================================="

echo "@@"
echo "@@--- SIM-12a  driver dissipation vs per-channel current, 5 V anode ---"
echo "@@ All 12 channels on at once = white at full brightness."
echo "@@"
echo "@@   I/ch    V_red_pin  V_gb_pin   P_red(W)  P_gb(W)   P_total(W)"
alterparam VANODE = 5.0
alterparam RBAL = 0.001
foreach il 5m 10m 15m 20m
  alterparam ILED = $il
  reset
  op > /dev/null
  let vr = v(rpin)
  let vg = v(gpin)
  let pr = 4 * vr * $il
  let pg = 8 * vg * $il
  let pt = pr + pg
  echo "@@   $il   $&vr   $&vg   $&pr   $&pg   $&pt"
end

echo "@@"
echo "@@--- SIM-12b  junction temperature, no ballast, 20 mA/ch ---"
echo "@@ TSSOP-28 theta_JA is board dependent; swept 60/80/100 C/W."
echo "@@"
echo "@@   theta_JA   Ta=25C    Ta=50C    Ta=60C    verdict@60C"
alterparam ILED = 20m
reset
op > /dev/null
let ptot = 4 * v(rpin) * 20m + 8 * v(gpin) * 20m
echo "@@   (P_total = $&ptot W)"
foreach th 60 80 100
  let tj25 = 25 + $&ptot * $th
  let tj50 = 50 + $&ptot * $th
  let tj60 = 60 + $&ptot * $th
  if ($&tj60 <= 100)
    echo "@@   $th         $&tj25   $&tj50   $&tj60   ok"
  else
    echo "@@   $th         $&tj25   $&tj50   $&tj60   OVER 100 C TARGET"
  end
end

echo "@@"
echo "@@--- SIM-12c  ballast resistor on the RED channels only ---"
echo "@@ Moves heat off the chip into a resistor JLC already places."
echo "@@ R chosen so the chip keeps >=0.8 V of output headroom at 20 mA."
echo "@@"
echo "@@   R_bal   V_red_pin  P_red_chip(W)  P_red_res(W)  P_total(W)  headroom"
alterparam ILED = 20m
foreach rb 0.001 33 47 68 82 100 120
  alterparam RBAL = $rb
  reset
  op > /dev/null
  let vrp = v(rpin)
  let prc = 4 * vrp * 20m
  let prr = 4 * $rb * 20m * 20m
  let pgb = 8 * v(gpin) * 20m
  let ptt = prc + pgb
  if ($&vrp >= 0.8)
    echo "@@   $rb   $&vrp   $&prc   $&prr   $&ptt   ok"
  else
    echo "@@   $rb   $&vrp   $&prc   $&prr   $&ptt   TOO LITTLE HEADROOM"
  end
end

echo "@@"
echo "@@--- SIM-12d  the cheap fix: cap global brightness in firmware ---"
echo "@@ TLC59116 has 8-bit per-channel PWM plus a global current control."
echo "@@ Average dissipation scales with duty. No BOM change at all."
echo "@@"
echo "@@   duty   P_avg(W)   Tj@Ta=60,theta=80   verdict"
alterparam RBAL = 0.001
alterparam ILED = 20m
reset
op > /dev/null
let pfull = 4 * v(rpin) * 20m + 8 * v(gpin) * 20m
foreach d 1.0 0.75 0.5 0.25 0.1
  let pav = pfull * $d
  let tj  = 60 + pav * 80
  if ($&tj <= 100)
    echo "@@   $d    $&pav   $&tj   ok"
  else
    echo "@@   $d    $&pav   $&tj   OVER 100 C TARGET"
  end
end

echo "@@"
echo "@@--- SIM-12e  worst realistic steady state: one indicator red, rest off"
echo "@@ The actual duty cycle of a status panel is nothing like white-full."
echo "@@"
alterparam ILED = 20m
reset
op > /dev/null
let p1red = 1 * v(rpin) * 20m
let tj1   = 60 + p1red * 80
echo "@@   single red indicator at full: P = $&p1red W, Tj@60C/80 = $&tj1 C"

echo "@@"
echo "@@--- SIM-12f  THE DECISION: Rext, with the chosen LED worst-case Vf ---"
echo "@@ IOUT = (1.25/Rext)*15, so Rext = 18.75/IOUT."
echo "@@ Tj at 60 C ambient, theta_JA 80 C/W, all 12 channels lit"
echo "@@ (full white self-test = the worst state the panel can be in)."
echo "@@"
echo "@@   I/ch(mA)   Rext(ohm)   P_total(W)   Tj@60C    verdict"
alterparam RBAL = 0.001
foreach il 0.02014 0.015625 0.0125 0.01003 0.00852 0.00625
  alterparam ILED = $il
  reset
  op > /dev/null
  let pt  = 4 * v(rpin) * $il + 8 * v(gpin) * $il
  let tj  = 60 + pt * 80
  let rx  = 18.75 / $il
  let ima = $il * 1000
  if ($&tj <= 100)
    echo "@@   $&ima   $&rx   $&pt   $&tj   ok"
  else
    echo "@@   $&ima   $&rx   $&pt   $&tj   OVER 100 C TARGET"
  end
end

quit
.endc

.end
