* SIM-12  TLC59116 power dissipation and junction temperature
*
* QUESTION
*   docs/04-pcb-1-front-control.md puts four RGB indicators on a TLC59116 in
*   TSSOP-28, with "LED anodes off the upper box's 5 V rail, driver logic on
*   3.3 V". Nobody has checked what that costs the driver in heat. A
*   constant-current sink burns (V_anode - Vf) * I in the chip, and a 5 V
*   anode against a ~2 V red LED burns most of it.
*
* WHY THE 5 V RAIL IS NOT FREE
*   The driver sinks current; whatever the LED does not drop, the chip does.
*     red   Vf ~1.9-2.2 V  ->  chip drops ~3.0 V
*     green Vf ~2.9-3.4 V  ->  chip drops ~1.9 V
*     blue  Vf ~2.9-3.4 V  ->  chip drops ~1.9 V
*   Red is therefore the hottest channel despite being the dimmest colour,
*   which is not obvious from the schematic.
*   (Vf ranges are from the LCSC listings for in-stock common-anode parts,
*   e.g. C404275 / C389528. No specific LED is chosen yet - docs/07-bom.md.)
*
* WHY NOT JUST USE 3.3 V FOR THE ANODES
*   Blue and green need 2.9-3.4 V plus the driver's own output headroom. A
*   3.3 V anode cannot guarantee full current into a 3.4 V blue die. So 5 V
*   is right for blue/green and wasteful for red. That asymmetry is the whole
*   finding here.
*
* MODEL
*   One channel = anode rail -> LED (modelled as a fixed Vf) -> optional
*   ballast R -> ideal current sink inside the chip. LED dynamic resistance
*   is ignored; for dissipation arithmetic at a fixed sink current that is
*   exact, because the sink sets the current regardless.
*
* IREF CAVEAT
*   The external IREF resistor that sets per-channel current is NOT computed
*   here - the TLC59116 datasheet formula has not been pulled. Current is
*   swept as an independent parameter instead.
*
* PASS CRITERIA
*   TLC59116 absolute max Tj = 125 C. Target Tj <= 100 C for margin.
*   Enclosure A is a sealed 3D print with an RK3588 in it and no measured
*   thermal solution (docs/02), so 50-60 C internal ambient is the honest
*   worst case, not 25 C.
*
* RESULT (run 2026-11-18 on fucina)
*   All 12 channels at 20 mA on a 5 V anode puts 0.544 W in a TSSOP-28.
*   At 60 C ambient that is Tj 103 C (theta 80) or 114 C (theta 100) -
*   over the 100 C target, under the 125 C max. Not a failure, but not
*   comfortable in an enclosure whose thermals are unmeasured.
*   Red is the problem: 3.0 V across the chip per red channel against
*   1.9 V for green/blue, so 4 red channels burn 44% of the total.
*   OPTIONS, cheapest first:
*     1. Cap global brightness at 75% in firmware -> 0.408 W, Tj 93 C.
*        No BOM change. SIM-12d.
*     2. 100 ohm ballast on the 4 red channels -> 0.384 W, keeps 1.0 V of
*        output headroom. 120 ohm leaves only 0.6 V and is too tight.
*     3. Both, if the enclosure measures hotter than 60 C.
*   AND NOTE: white-at-full is not a real state for a status panel. One
*   red indicator lit is 0.060 W, Tj 65 C. The thermal case only exists
*   for a full-white self-test, so bounding THAT in firmware is enough.

.title SIM-12 TLC59116 dissipation

.param ILED  = 20m
.param VFRED = 2.0
.param VFGB  = 3.1
.param VANODE = 5.0
.param RBAL  = 0.001

Vanode anode 0 DC {VANODE}

* --- one red channel ---
Vfr    anode  rmid  DC {VFRED}
Rbr    rmid   rpin  {RBAL}
Ir     rpin   0     DC {ILED}

* --- one green/blue channel ---
Vfg    anode  gmid  DC {VFGB}
Rbg    gmid   gpin  0.001
Ig     gpin   0     DC {ILED}

.control
echo "@@=============================================================="
echo "@@ SIM-12  TLC59116 dissipation, 4 RGB indicators (12 channels)"
echo "@@ 4 red + 8 green/blue. Tj target <= 100 C, abs max 125 C."
echo "@@=============================================================="

echo "@@"
echo "@@--- SIM-12a  driver dissipation vs per-channel current, 5 V anode ---"
echo "@@ All 12 channels on at once = white at full brightness."
echo "@@"
echo "@@   I/ch    V_red_pin  V_gb_pin   P_red(W)  P_gb(W)   P_total(W)"
alterparam VANODE = 5.0
alterparam RBAL = 0.001
foreach il 5m 10m 15m 20m
  alterparam ILED = $il
  reset
  op > /dev/null
  let vr = v(rpin)
  let vg = v(gpin)
  let pr = 4 * vr * $il
  let pg = 8 * vg * $il
  let pt = pr + pg
  echo "@@   $il   $&vr   $&vg   $&pr   $&pg   $&pt"
end

echo "@@"
echo "@@--- SIM-12b  junction temperature, no ballast, 20 mA/ch ---"
echo "@@ TSSOP-28 theta_JA is board dependent; swept 60/80/100 C/W."
echo "@@"
echo "@@   theta_JA   Ta=25C    Ta=50C    Ta=60C    verdict@60C"
alterparam ILED = 20m
reset
op > /dev/null
let ptot = 4 * v(rpin) * 20m + 8 * v(gpin) * 20m
echo "@@   (P_total = $&ptot W)"
foreach th 60 80 100
  let tj25 = 25 + $&ptot * $th
  let tj50 = 50 + $&ptot * $th
  let tj60 = 60 + $&ptot * $th
  if ($&tj60 <= 100)
    echo "@@   $th         $&tj25   $&tj50   $&tj60   ok"
  else
    echo "@@   $th         $&tj25   $&tj50   $&tj60   OVER 100 C TARGET"
  end
end

echo "@@"
echo "@@--- SIM-12c  ballast resistor on the RED channels only ---"
echo "@@ Moves heat off the chip into a resistor JLC already places."
echo "@@ R chosen so the chip keeps >=0.8 V of output headroom at 20 mA."
echo "@@"
echo "@@   R_bal   V_red_pin  P_red_chip(W)  P_red_res(W)  P_total(W)  headroom"
alterparam ILED = 20m
foreach rb 0.001 33 47 68 82 100 120
  alterparam RBAL = $rb
  reset
  op > /dev/null
  let vrp = v(rpin)
  let prc = 4 * vrp * 20m
  let prr = 4 * $rb * 20m * 20m
  let pgb = 8 * v(gpin) * 20m
  let ptt = prc + pgb
  if ($&vrp >= 0.8)
    echo "@@   $rb   $&vrp   $&prc   $&prr   $&ptt   ok"
  else
    echo "@@   $rb   $&vrp   $&prc   $&prr   $&ptt   TOO LITTLE HEADROOM"
  end
end

echo "@@"
echo "@@--- SIM-12d  the cheap fix: cap global brightness in firmware ---"
echo "@@ TLC59116 has 8-bit per-channel PWM plus a global current control."
echo "@@ Average dissipation scales with duty. No BOM change at all."
echo "@@"
echo "@@   duty   P_avg(W)   Tj@Ta=60,theta=80   verdict"
alterparam RBAL = 0.001
alterparam ILED = 20m
reset
op > /dev/null
let pfull = 4 * v(rpin) * 20m + 8 * v(gpin) * 20m
foreach d 1.0 0.75 0.5 0.25 0.1
  let pav = pfull * $d
  let tj  = 60 + pav * 80
  if ($&tj <= 100)
    echo "@@   $d    $&pav   $&tj   ok"
  else
    echo "@@   $d    $&pav   $&tj   OVER 100 C TARGET"
  end
end

echo "@@"
echo "@@--- SIM-12e  worst realistic steady state: one indicator red, rest off"
echo "@@ The actual duty cycle of a status panel is nothing like white-full."
echo "@@"
alterparam ILED = 20m
reset
op > /dev/null
let p1red = 1 * v(rpin) * 20m
let tj1   = 60 + p1red * 80
echo "@@   single red indicator at full: P = $&p1red W, Tj@60C/80 = $&tj1 C"

quit
.endc

.end
