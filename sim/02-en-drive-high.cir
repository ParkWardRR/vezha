* SIM-02  Can the Pico still drive EN high through a 1.5k pull-down?
*
* SIM-01 pushes the pull-down down to 1.5 kohm to beat the module's 1 Mohm
* pull-up to 48 V plus RP2350-E9 leakage. The obvious objection is that a
* pull-down that strong might stop the Pico asserting EN at all. Check it,
* and check the pad current stays inside the GPIO's drive rating.
*
* Pololu EN needs > 1.0 V to leave shutdown.
* The 1 Mohm to VIN HELPS when driving high, so the worst case for this test
* is VIN at its LOWEST (5 V), where the pull-up contributes almost nothing.
*
* Pad modelled as 3.3 V behind a pad resistance. RP2350 GPIO drive strength is
* selectable 2/4/8/12 mA; 50 ohm is an optimistic effective Ron and 200 ohm a
* pessimistic one at the weakest setting.
*
* PASS CRITERION  V(en) > 1.0 V with margin, pad current well under the
* selected drive strength.

.title SIM-02 EN drive high

.param RPD  = 1.5k
.param RPAD = 50

Vin   vin  0   DC 5
Vgpio gpio 0   DC 3.3
Rpad  gpio en  {RPAD}
Rpu   vin  en  1MEG
Rpd   en   0   {RPD}

.control
echo "@@=============================================================="
echo "@@ SIM-02  Pico asserting EN through the SIM-01 pull-down"
echo "@@ VIN = 5 V (worst case for driving high). EN must exceed 1.000 V"
echo "@@=============================================================="
echo "@@"
echo "@@   Rpd    Rpad   V(en)      I_pad(mA)   P_Rpd(mW)  verdict"
foreach rpd 1k 1.5k 2.2k 4.7k
  alterparam RPD = $rpd
  foreach rpad 50 100 200
    alterparam RPAD = $rpad
    reset
    op
    let ven  = v(en)
    let ipad = (3.3 - v(en)) / $rpad * 1000
    let pr   = v(en)*v(en)/$rpd*1000
    if ($&ven > 1.0)
      echo "@@  $rpd   $rpad   $&ven  $&ipad   $&pr   PASS"
    else
      echo "@@  $rpd   $rpad   $&ven  $&ipad   $&pr   FAIL - EN not asserted"
    end
  end
end
quit
.endc
.end
