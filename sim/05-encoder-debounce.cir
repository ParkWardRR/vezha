* SIM-05  Encoder debounce: RC on board vs firmware
*
* QUESTION
*   docs/05-pcb-2-power.md leaves this open: "A, B and the switch need
*   pull-ups and debouncing - RC on-board or internal pull-ups plus firmware
*   debounce. Decide before layout; the RC parts need footprints."
*
* THE TWO CONSTRAINTS
*   1. Contact bounce. An Alps EC11 contact chatters on each transition.
*      Real bounce is FAST chatter - tens of microseconds per pulse - spread
*      over a window of 1-3 ms. Modelled here as ~30 us closures separated by
*      ~30-250 us openings across a 2 ms window, which is a nasty case.
*   2. Fast rotation. EC11E15244B2 has 30 detents/rev, one full A/B
*      quadrature cycle per detent, so 4 edges per detent:
*         edge spacing = 1 / (rev_per_s * 30 * 4)
*         3 rev/s -> 2.78 ms      5 rev/s -> 1.67 ms
*      3 rev/s is a brisk flick, 5 rev/s about as fast as a knob this size
*      can be turned by hand.
*
* TOPOLOGY
*   +3V3 --[Rpu 10k]-- SWN --[Rs 1k]-- GPIO
*                       |                |
*                    contact           [Cf]
*                       |                |
*                      GND              GND
*   The two time constants are ASYMMETRIC, and the asymmetry is the point:
*     closing (fall): tau = Cf * (Rs || Rpu) = Cf * 909 ohm   fast assert
*     opening (rise): tau = Cf * (Rs + Rpu)  = Cf * 11k       slow release
*   A slow release is what rejects bounce, because bounce is a series of brief
*   OPEN excursions during a closure, and the node cannot climb back to VIH
*   inside one. The same slow release is what eventually limits rotation
*   speed, so there is a real ceiling on Cf - SIM-05d finds it.
*
*   RP2350 GPIO inputs are Schmitt-triggered. Conservative CMOS levels at
*   3.3 V IOVDD used as decision thresholds:  VIL = 0.8 V, VIH = 2.0 V.
*
* WHAT SIM-05 DECIDES
*   (b) does a real closure get through at 3 and 5 rev/s?
*   (c) is the bounce burst suppressed?
*   (d) what rotation rate does each Cf top out at?
*   A Cf is usable only if it passes both (b) and (c).

.title SIM-05 encoder debounce

.param CF = 100e-9

.model CONTACT SW vt=1.65 vh=0.1 ron=5 roff=100MEG

V3v3 vdd 0 DC 3.3
Rpu  vdd swn  10k
Rs   swn gpio 1k
Cf   gpio 0   {CF}
Sw   swn 0 ctl 0 CONTACT

* ctl high = contact closed.
*   0  - 10 ms    open, settled
*  10  - 12 ms    BOUNCE BURST while closing (fast chatter)
*  12  - 20 ms    closed, settled
*  20 ms          clean open
*  30 - 32.78 ms  clean 2.78 ms closure = 3 rev/s
*  40 - 41.67 ms  clean 1.67 ms closure = 5 rev/s
Vctl ctl 0 PWL
+ 0m 0
+ 9.9990m 0     10.0000m 3.3
+ 10.0300m 3.3  10.0310m 0
+ 10.0600m 0    10.0610m 3.3
+ 10.0900m 3.3  10.0910m 0
+ 10.1500m 0    10.1510m 3.3
+ 10.1900m 3.3  10.1910m 0
+ 10.3000m 0    10.3010m 3.3
+ 10.3400m 3.3  10.3410m 0
+ 10.5500m 0    10.5510m 3.3
+ 10.6000m 3.3  10.6010m 0
+ 10.8500m 0    10.8510m 3.3
+ 10.9000m 3.3  10.9010m 0
+ 11.1500m 0    11.1510m 3.3
+ 11.2000m 3.3  11.2010m 0
+ 11.4500m 0    11.4510m 3.3
+ 11.5000m 3.3  11.5010m 0
+ 11.7500m 0    11.7510m 3.3
+ 19.9990m 3.3  20.0000m 0
+ 29.9990m 0    30.0000m 3.3
+ 32.7800m 3.3  32.7810m 0
+ 39.9990m 0    40.0000m 3.3
+ 41.6700m 3.3  41.6710m 0
+ 50.0000m 0

.control
echo "@@=============================================================="
echo "@@ SIM-05  Encoder RC debounce. Rpu = 10k, Rs = 1k, Cf swept"
echo "@@ Decision levels at 3.3 V IOVDD: VIL 0.800 V, VIH 2.000 V"
echo "@@=============================================================="

echo "@@"
echo "@@--- SIM-05a  time constants and derived timings ---"
echo "@@"
echo "@@   Cf        tau_fall(us)  tau_rise(us)  t_rise_to_VIH(us)"
foreach cf 1e-9 10e-9 100e-9 220e-9 1e-6
  let tf = $cf * 909 * 1e6
  let tr = $cf * 11e3 * 1e6
  let th = $cf * 11e3 * 0.93179 * 1e6
  echo "@@   $cf    $&tf    $&tr    $&th"
end

echo "@@"
echo "@@--- SIM-05b  do real closures get through? ---"
echo "@@  sampled near the end of each clean closure"
echo "@@  3 rev/s: closed 30.00-32.78 ms, sampled 32.70 ms"
echo "@@  5 rev/s: closed 40.00-41.67 ms, sampled 41.60 ms"
echo "@@  must fall below VIL = 0.800 V to be counted"
echo "@@"
echo "@@   Cf        V@32.70ms   3rev/s   V@41.60ms   5rev/s"
foreach cf 1e-9 10e-9 100e-9 220e-9 1e-6
  alterparam CF = $cf
  reset
  tran 2u 50m
  meas tran v3 FIND v(gpio) AT=32.70m > /dev/null
  meas tran v5 FIND v(gpio) AT=41.60m > /dev/null
  if ($&v3 < 0.8)
    set r3 = "SEEN"
  else
    set r3 = "MISSED"
  end
  if ($&v5 < 0.8)
    set r5 = "SEEN"
  else
    set r5 = "MISSED"
  end
  echo "@@   $cf    $&v3   $r3   $&v5   $r5"
end

echo "@@"
echo "@@--- SIM-05c  is the bounce burst suppressed? ---"
echo "@@  The question is NOT whether the node wobbles during the burst - it"
echo "@@  always does, and early chatter pulses may be too short to assert at"
echo "@@  all. A spurious edge means: once the GPIO has ALREADY read a valid"
echo "@@  low (node crossed VIL = 0.8 V), does the node climb back above"
echo "@@  VIH = 2.0 V before the closure genuinely ends at 20 ms?"
echo "@@  So: find the first VIL crossing, then take the peak from there to"
echo "@@  19.9 ms. Peak above VIH = a false release the decoder would count."
echo "@@"
echo "@@   Cf        t_first_assert(ms)  peak V after it   result"
foreach cf 1e-9 10e-9 100e-9 220e-9 1e-6
  alterparam CF = $cf
  reset
  tran 2u 50m
  meas tran tas WHEN v(gpio)=0.8 FALL=1 > /dev/null
  let tasms = $&tas * 1000
  meas tran vpk MAX v(gpio) FROM=$&tas TO=19.9m > /dev/null
  if ($&vpk > 2.0)
    echo "@@   $cf    $&tasms    $&vpk    FAIL - false release, extra edges"
  else
    echo "@@   $cf    $&tasms    $&vpk    PASS - bounce suppressed"
  end
end

echo "@@"
echo "@@--- SIM-05d  rotation-rate ceiling each Cf imposes ---"
echo "@@  The slow rise sets it: min edge spacing = t_rise_to_VIH"
echo "@@  rev/s = 1 / (4 * 30 * min_edge_spacing)"
echo "@@  For reference, a brisk hand flick is about 3 rev/s = 180 RPM."
echo "@@"
echo "@@   Cf        min edge spacing(us)  max rev/s   max RPM"
foreach cf 1e-9 10e-9 100e-9 220e-9 1e-6
  let sp = $cf * 11e3 * 0.93179 * 1e6
  let rs = 1 / ($cf * 11e3 * 0.93179 * 120)
  let rpm = 60 / ($cf * 11e3 * 0.93179 * 120)
  echo "@@   $cf    $&sp    $&rs    $&rpm"
end
quit
.endc
.end
