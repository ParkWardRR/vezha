* SIM-06  Key input: pull-up, RC debounce, and whether hardware is needed
*
* QUESTION
*   docs/04 wires each key as "switch to ground" on an Orange Pi GPIO and
*   does not say where the pull-up lives or whether anything filters bounce.
*   docs/05 asks the same thing about the EC11 encoder ("Encoder debounce: RC
*   on board vs. firmware"). Answer it once, the same way, for both boards.
*
* WHAT CHANGED
*   The switch is now the C&K KSC221JLFS (docs/07-bom.md), not the APEM 6C.
*   C&K specifies bounce for its KSC tactiles at <= 5 ms. That figure is
*   taken as the design input here; it has NOT been pulled from the
*   KSC221JLFS datasheet specifically, so 10 ms is also swept.
*
* RK3588 INTERNAL PULL-UP
*   Unverified. RK3588 GPIO internal pull-ups are in the tens of kohm; 50 k
*   is the usual figure quoted and is swept against 20 k and 80 k. Note the
*   internal pull-up cannot be relied on during boot before pinmux runs,
*   which is the argument for an external one regardless of filtering.
*
* TOPOLOGY
*   3.3 V -- Rpu -- node gpio -- Rs -- switch -- GND,  Cf from gpio to GND.
*   Rs in series with the switch limits the capacitor discharge current and
*   is what makes an RC filter actually work on a grounding switch; without
*   it the switch shorts Cf straight to 0 V and the falling edge is unfiltered.
*
* PASS CRITERIA
*   1. A 5 ms bounce burst must produce exactly ONE clean crossing of each
*      logic threshold (V_IL 0.8 V / V_IH 2.0 V for a 3.3 V CMOS input).
*   2. Rise back to V_IH after release must stay well under the ~50 ms a
*      human notices, so the key does not feel laggy.
*   3. No hardware should be added if firmware debounce alone is sufficient.
*
* RESULT (run 2026-11-18 on fucina)
*   HARDWARE RC DEBOUNCE DOES NOT WORK HERE, and the reason is structural,
*   not a sizing miss. On a switch-to-ground input, Rs must be much smaller
*   than Rpu or the closed switch cannot pull a valid low - with Rs 1 k and
*   Rpu 10 k the low sits at 0.30 V, already a tenth of the rail. But that
*   same small Rs is what discharges Cf, so the discharge time constant is
*   forced to be far shorter than the charge one. Sweeping Cf from 10 nF to
*   470 nF never masks the 5 ms bounce burst: V_min only moves 0.300 -> 0.407 V,
*   still well under V_IL. Making Rs large enough to help (10 k) would put
*   the closed-switch level at 1.65 V, above V_IL, so the key would never
*   read as pressed at all.
*   ACTION: debounce in FIRMWARE. Do not fit debounce capacitors.
*   Keep a 10 k external pull-up anyway - not for bounce, but so the input
*   has a defined level before pinmux runs. It also settles in 0.84 ms
*   against 7.35 ms for an 80 k internal pull-up (SIM-06d).
*   Optional 10-100 nF to ground is defensible for ESD/EMI only; it buys
*   nothing for bounce and should not be described as debounce.
*   This answers docs/05's "encoder debounce: RC on board vs firmware" the
*   same way, for the same reason.

.title SIM-06 key input debounce

.param RPU = 10k
.param RS  = 1k
.param CF  = 100n

Vdd  vdd  0  DC 3.3
Rpu  vdd  gpio  {RPU}
Cf   gpio 0     {CF}
Rs   gpio sw    {RS}

* Contact bounce: 5 bounces over ~5 ms, then solid closure, release at 60 ms.
* ctl high = contact closed.
Vctl ctl 0 PWL(0 0  9.999m 0  10m 3  10.4m 3  10.5m 0  11.0m 0
+              11.1m 3  11.6m 3  11.7m 0  12.3m 0
+              12.4m 3  13.1m 3  13.2m 0  14.0m 0
+              14.1m 3  60m 3  60.001m 0  200m 0)
Ssw  sw  0  ctl 0 swmod
.model swmod sw vt=1.5 ron=1 roff=1e12

.control
echo "@@=============================================================="
echo "@@ SIM-06  Key input - pull-up and debounce"
echo "@@ Thresholds: V_IL 0.800 V, V_IH 2.000 V on a 3.3 V input"
echo "@@=============================================================="

echo "@@"
echo "@@--- SIM-06a  NO filter (Cf=0): how dirty is the raw edge? ---"
echo "@@ Expect the GPIO to follow every bounce. This is the baseline."
echo "@@"
echo "@@   Rpu      edges_below_VIL   (count of separate low excursions)"
alterparam CF = 1f
alterparam RS = 1k
foreach rpu 20k 50k 80k 10k
  alterparam RPU = $rpu
  reset
  tran 10u 80m
  * count threshold crossings by sampling; a clean press gives 1
  meas tran n1 FIND v(gpio) AT=10.2m > /dev/null
  meas tran n2 FIND v(gpio) AT=10.8m > /dev/null
  meas tran n3 FIND v(gpio) AT=11.4m > /dev/null
  meas tran n4 FIND v(gpio) AT=12.0m > /dev/null
  meas tran n5 FIND v(gpio) AT=13.6m > /dev/null
  echo "@@   $rpu   samples through the bounce burst (V):"
  echo "@@            t=10.2m $&n1   t=10.8m $&n2   t=11.4m $&n3   t=12.0m $&n4   t=13.6m $&n5"
end

echo "@@"
echo "@@--- SIM-06b  RC filter sizing, Rpu=10k external, Rs=1k ---"
echo "@@ Does the GPIO stay above V_IL through the whole bounce burst,"
echo "@@ i.e. does the filter hide the bounce completely?"
echo "@@"
echo "@@   Cf      V_min_during_bounce   t_fall_to_VIL(ms)   verdict"
alterparam RPU = 10k
alterparam RS  = 1k
foreach cf 1f 10n 47n 100n 220n 470n
  alterparam CF = $cf
  reset
  tran 10u 80m
  meas tran vmin MIN v(gpio) FROM=10m TO=14m > /dev/null
  meas tran tf WHEN v(gpio)=0.8 FALL=1 > /dev/null
  let tfms = (tf - 10m) * 1000
  if ($&vmin > 0.8)
    echo "@@   $cf    $&vmin    (never crosses)    BOUNCE FULLY MASKED"
  else
    echo "@@   $cf    $&vmin    $&tfms    crosses V_IL"
  end
end

echo "@@"
echo "@@--- SIM-06c  release-edge latency with the filter in place ---"
echo "@@ Rising back through V_IH after the key is let go at t=60 ms."
echo "@@ Must be far below ~50 ms or the key feels sticky."
echo "@@"
echo "@@   Cf      t_rise_to_VIH(ms)   verdict"
foreach cf 1f 10n 47n 100n 220n 470n
  alterparam CF = $cf
  reset
  tran 10u 120m
  meas tran trr WHEN v(gpio)=2.0 RISE=LAST > /dev/null
  let trms = (trr - 60m) * 1000
  if ($&trms < 50)
    echo "@@   $cf    $&trms   ok"
  else
    echo "@@   $cf    $&trms   TOO SLOW - key feels laggy"
  end
end

echo "@@"
echo "@@--- SIM-06d  the case for an external pull-up at all ---"
echo "@@ With only the SBC internal pull-up (and no external), the node is"
echo "@@ undriven until pinmux configures it. Compare settle time from 0 V."
echo "@@"
echo "@@   Rpu      Cf=100n: t_rise_to_VIH(ms)"
alterparam CF = 100n
foreach rpu 80k 50k 20k 10k 4.7k
  alterparam RPU = $rpu
  reset
  tran 10u 120m
  meas tran trr WHEN v(gpio)=2.0 RISE=LAST > /dev/null
  let trms = (trr - 60m) * 1000
  echo "@@   $rpu     $&trms"
end

quit
.endc

.end
