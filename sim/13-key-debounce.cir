* SIM-13  Key input: pull-up and RC debounce
*
* RETIRED 2026-11-18 -- PCB 1 is not built in v1. There are no keys. See
*   docs/01 "The v1 scope cut". Kept for v2, and worth keeping: this deck
*   was CORRECTED in a4c5201 after its first pass asked the wrong question
*   (whether the filter hides bounce entirely, rather than whether a second
*   edge appears after the input has already read a valid low). The
*   corrected answer -- 10k / 1k / 100 nF, a window and not a floor -- is
*   the one that converges with PCB 2's encoder deck, sim/05.
*
* QUESTION
*   docs/04 wires each key as "switch to ground" on an Orange Pi GPIO and
*   does not say where the pull-up lives or whether anything filters bounce.
*   docs/05 asked the same about the EC11 encoder. Answer it once for both.
*
* CORRECTED 2026-11-18 - THIS DECK PREVIOUSLY REACHED THE WRONG ANSWER
*   The first version of this deck concluded "hardware RC cannot work here".
*   That conclusion came from the WRONG PASS CRITERION, not from bad numbers.
*   It asked whether the filter keeps the node ABOVE V_IL for the whole bounce
*   burst - i.e. whether bounce is hidden entirely. That is far stricter than
*   debounce requires and essentially nothing passes it.
*   The right question, which the PCB 2 encoder deck (sim/05) asked correctly:
*     once the input has ALREADY read a valid low, does it climb back above
*     V_IH and manufacture a SECOND edge?
*   Credit where due: that framing came from the PCB 2 work.
*
*   The topology's asymmetry is what makes it work, and it is easy to miss:
*     falling edge: discharge through Rs (fast)
*     rising edge:  charge through Rs + Rpu (slow)
*   So a closure stays crisp while a brief contact opening cannot recover to
*   V_IH. Asymmetric time constants are the whole mechanism.
*
* IT ALSO USED THE WRONG BOUNCE FIGURE
*   The first version invented a 5 ms burst with 500-900 us openings. The C&K
*   datasheet for the KSC series states BOUNCE TIME <= 1 ms (page B-49).
*   This version models chatter inside that 1 ms, which is what the chosen
*   switch actually does.
*
* RK3588 INTERNAL PULL-UP
*   Still unverified; tens of kohm is the usual figure. Swept in SIM-13d.
*   It also cannot be relied on before pinmux runs, which is an argument for
*   an external pull-up independent of anything to do with bounce.
*
* TOPOLOGY
*   3.3 V -- Rpu -- gpio -- Rs -- switch -- GND,  Cf from gpio to GND.
*
* RESULT (run 2026-11-18 on fucina, corrected deck)
*   FIT THE RC. The previous "firmware only, no capacitors" answer was wrong.
*     Cf       V_peak after first low (V_IH = 2.0)      verdict
*     1n       3.300                                     FAIL, bounce passes straight through
*     10n      2.195                                     FAIL, spurious edge
*     47n      1.086                                     PASS, best margin
*     100n     1.627                                     PASS
*     220n     2.314                                     FAIL - see below
*     470n     never reaches a valid low                 FAIL
*   There is a WINDOW, not a floor: too much capacitance fails too, because
*   the cap stops discharging fully during the short closures. 220 nF only
*   gets down to 0.650 V and then wanders back over V_IH.
*   CHOSEN: Cf = 100 nF, Rpu = 10 k, Rs = 1 k. Same values as the PCB 2
*   encoder, so one BOM line covers both boards, and PCB 2 validated 100 nF
*   against a harder stimulus (30 us chatter) than this switch produces.
*   47 nF is the higher-margin alternative if the coupon shows double presses.
*   Rs cannot be grown to filter on its own: at 3.3 k the closed-switch level
*   is 0.819 V, already over V_IL, and the key stops registering (SIM-13b).
*   Keep the 10 k EXTERNAL pull-up regardless of bounce - an internal pull-up
*   is not active before pinmux, and 10 k settles in 0.84 ms against 7.36 ms
*   for an 80 k internal (SIM-13d).
*
* PASS CRITERIA
*   1. NO SECOND EDGE: after the node first crosses below V_IL, it must not
*      climb back above V_IH (2.0 V) for the rest of the bounce burst.
*   2. The closure must actually register: node must reach below V_IL.
*   3. Release must return above V_IH well inside ~50 ms or the key feels
*      sticky.
*   4. A valid low must be a valid low: the divider Rs/(Rs+Rpu) at steady
*      closure must sit below V_IL.

.title SIM-13 key input debounce

.param RPU = 10k
.param RS  = 1k
.param CF  = 100n

Vdd  vdd  0  DC 3.3
Rpu  vdd  gpio  {RPU}
Cf   gpio 0     {CF}
Rs   gpio sw    {RS}

* Contact closes at 10 ms. Chatter confined to <= 1 ms per the C&K spec:
* closed 80us, open 70us, closed 150us, open 100us, closed 200us, open 50us,
* then solid. Settled by 10.65 ms. Released at 60 ms.
Vctl ctl 0 PWL(0 0  9.999m 0
+              10.000m 3  10.080m 3  10.085m 0  10.150m 0
+              10.155m 3  10.300m 3  10.305m 0  10.400m 0
+              10.405m 3  10.600m 3  10.605m 0  10.650m 0
+              10.655m 3  60.000m 3  60.005m 0  200m 0)
Ssw  sw  0  ctl 0 swmod
.model swmod sw vt=1.5 ron=1 roff=1e12

.control
echo "@@=============================================================="
echo "@@ SIM-13  Key input - pull-up and RC debounce  [CORRECTED]"
echo "@@ Switch: C&K KSC221JLFS, datasheet bounce time <= 1 ms"
echo "@@ Thresholds: V_IL 0.800 V, V_IH 2.000 V on a 3.3 V input"
echo "@@ PASS = node reads a valid low AND never recovers to V_IH"
echo "@@        again before the contact is solid."
echo "@@=============================================================="

echo "@@"
echo "@@--- SIM-13a  the real test: does the filter prevent a 2nd edge? ---"
echo "@@ Rpu = 10k, Rs = 1k. V_peak is the highest the node reaches AFTER"
echo "@@ it has already read a valid low, during the chatter."
echo "@@"
echo "@@   Cf      V_min     V_peak_after_low   2nd edge?   verdict"
alterparam RPU = 10k
alterparam RS  = 1k
foreach cf 1f 1n 10n 47n 100n 220n 470n
  alterparam CF = $cf
  reset
  tran 2u 70m
  meas tran vmin MIN v(gpio) FROM=10.0m TO=10.7m > /dev/null
  meas tran vpk  MAX v(gpio) FROM=10.09m TO=10.65m > /dev/null
  if ($&vmin > 0.8)
    echo "@@   $cf    $&vmin   $&vpk   -   FAIL never reads low"
  else
    if ($&vpk >= 2.0)
      echo "@@   $cf    $&vmin   $&vpk   YES   FAIL spurious edge"
    else
      echo "@@   $cf    $&vmin   $&vpk   no    PASS"
    end
  end
end

echo "@@"
echo "@@--- SIM-13b  steady-state low must be a valid low ---"
echo "@@ V_low = 3.3 * Rs/(Rs+Rpu). Must be under V_IL 0.8 V."
echo "@@ This is what stops Rs being made large enough to filter on its own."
echo "@@"
echo "@@   Rs      Rpu=10k: V_low    verdict"
foreach rs 100 470 1k 2.2k 3.3k 10k
  let vlow = 3.3 * $rs / ($rs + 10000)
  if ($&vlow < 0.8)
    echo "@@   $rs    $&vlow   ok"
  else
    echo "@@   $rs    $&vlow   INVALID LOW - key never registers"
  end
end

echo "@@"
echo "@@--- SIM-13c  release latency with the filter fitted ---"
echo "@@ Rising back through V_IH after release at 60 ms."
echo "@@"
echo "@@   Cf      t_rise_to_VIH(ms)   verdict"
alterparam RPU = 10k
alterparam RS  = 1k
foreach cf 10n 47n 100n 220n 470n
  alterparam CF = $cf
  reset
  tran 2u 120m
  meas tran trr WHEN v(gpio)=2.0 RISE=LAST > /dev/null
  let trms = (trr - 60m) * 1000
  if ($&trms < 50)
    echo "@@   $cf    $&trms   ok"
  else
    echo "@@   $cf    $&trms   TOO SLOW - key feels sticky"
  end
end

echo "@@"
echo "@@--- SIM-13d  why an EXTERNAL pull-up, not the SBC's internal one ---"
echo "@@ Settle time from release, Cf = 100 nF. Also: an internal pull-up"
echo "@@ is not active until pinmux runs, so the input floats before that."
echo "@@"
echo "@@   Rpu      t_rise_to_VIH(ms)"
alterparam CF = 100n
foreach rpu 80k 50k 20k 10k 4.7k
  alterparam RPU = $rpu
  reset
  tran 2u 120m
  meas tran trr WHEN v(gpio)=2.0 RISE=LAST > /dev/null
  let trms = (trr - 60m) * 1000
  echo "@@   $rpu     $&trms"
end

quit
.endc

.end
